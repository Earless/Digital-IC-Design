;The following lines were added by spc install program
;Modified on "Aug  5 17:36:54 1999"
load(strcat(ddGetObjReadPath(ddGetObj("cellTechLib")) "/examplePcellLib/spcLoadUtilities.il"))
load(strcat(ddGetObjReadPath(ddGetObj("cellTechLib")) "/examplePcellLib/utility.il"))
load(strcat(ddGetObjReadPath(ddGetObj("cellTechLib")) "/examplePcellLib/inv.callback"))
load(strcat(ddGetObjReadPath(ddGetObj("cellTechLib")) "/examplePcellLib/inv.il"))
load(strcat(ddGetObjReadPath(ddGetObj("cellTechLib")) "/examplePcellLib/mos.callback"))
load(strcat(ddGetObjReadPath(ddGetObj("cellTechLib")) "/examplePcellLib/mos.il"))
;end of the spc install program modifications
