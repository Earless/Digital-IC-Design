// Exercise 3.11
// Run with:
//     spectre 3_11.scs
//     wavescan -datadir 3_11.raw
//
simulator lang=spectre
include "g25_scs.lib"

parameters par=1

vin3 (vin 0) vsource dc = par
vdd3 (vdd 0) vsource dc = 2.5

m3 (vdd vin 0 0) nmos l=0.25u w=1u

swp1 sweep param=par values=[0 0.5 1 1.5 2 2.5] {
		Inputsweep dc param=dc dev=vdd3 start=0 stop=2.5 step=0.1
}

//Inputsweep dc param=dc dev=vin start=0 stop=2.5 step=0.1

//save vin out_long out_short
save m3:d
save vdd3
save vin3

// end
